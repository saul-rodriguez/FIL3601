ADE simulation setup
Run mode: Single Run, Sweeps and Corners
Tests:
  DAY5:EXAMPLE:1: DAY5/EXAMPLE/schematic, simulator spectre
Global variables:
  IDS = 10u
  L = 1u
  NF = 8
  VDS = 0.9
  VGS = 0.3723
  WF = 10u
