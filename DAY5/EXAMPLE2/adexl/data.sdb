ADE simulation setup
Run mode: Single Run, Sweeps and Corners
Tests:
  DAY5:EXAMPLE2:1: DAY5/EXAMPLE2/schematic, simulator spectre
Global variables:
  IDS = 400u
  L = 0.5u
  NF = 50
  VDS = 0.9
  VGS = 0.4386
  WF = 10u
  R1 = 300
  R2 = 2700
  RS = 1000
