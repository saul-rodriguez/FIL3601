ADE simulation setup
Run mode: Single Run, Sweeps and Corners
Tests:
  1k (off): DAY6/ex1/schematic, simulator spectre
    Outputs: dB20(leafValue(VF("/VOUT") "VPULSE" 0)); dB20(VF("/VOUT"))
  3M: DAY6/ex1/schematic, simulator spectre
    Outputs: dB20(leafValue(VF("/VOUT") "VPULSE" 0)); dB20(VF("/VOUT"))
  SR (off): DAY6/ex1/schematic, simulator spectre
    Outputs: dB20(leafValue(VF("/VOUT") "VPULSE" 0)); dB20(VF("/VOUT")); SR
Global variables:
  FREQ = 1k (off)
  VIN = 0 (off)
  VPULSE = 500m (off)
