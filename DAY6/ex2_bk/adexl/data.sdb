ADE simulation setup
Run mode: Single Run, Sweeps and Corners
Tests:
  DAY6:ex2:1 (off): DAY6/ex2/schematic, simulator spectre
    Outputs: deriv(VS("/VOUT2")); GQ; GP; GM; nil; em
  DAY6:ex2:2: DAY6/ex2/schematic, simulator spectre
Global variables:
  VIN2 = 0
  VIN = 0
