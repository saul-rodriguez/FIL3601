ADE simulation setup
Run mode: Single Run, Sweeps and Corners
Tests:
  DAY6:ex3:1: DAY6/ex3/schematic, simulator spectre
Global variables:
  FREQ = 1k
  VIN = 300m
  VPULSE = 0
