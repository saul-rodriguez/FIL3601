ADE simulation setup
Run mode: Single Run, Sweeps and Corners
Tests:
  AC_NOISE_PZ_TRANS_PSRR (off): EX1/current_amplifier_final_tb/schematic, simulator spectre
    Outputs: Gain_dB; Bandwidth_3dB; PSRR
  TRAN_PULSE_IN (off): EX1/current_amplifier_final_tb/schematic, simulator spectre
    Outputs: SR_[A/S]
  TRAN_PULSE_VDD (off): EX1/current_amplifier_final_tb/schematic, simulator spectre
  INTERMODULATION (off): EX1/current_amplifier_final_tb/schematic, simulator spectre
  AC_NOISE_PZ_TRANS_PSRR_MC (off): EX1/current_amplifier_final_tb/schematic, simulator spectre
    Outputs: Gain_dB; Bandwidth_3dB; PSRR
Global variables:
  IN = 1
  IN_DC = 0
  IN_PULSE = 0 (off)
  VDD = 1.8 (off)
  VDD_PULSE = 0 (off)
  AMP1 = 2u (off)
  AMP2 = 0 (off)
  FREQ1 = 10M (off)
  FREQ2 = 0 (off)
  BIAS_PULSE = 0 (off)
Corners (all switched off):
  every corner: /pkg/xfab2/XKIT/xh018/cadence/v9_0/spectre/v9_0_2/lpmos/config.scs[default], /pkg/xfab2/XKIT/xh018/cadence/v9_0/spectre/v9_0_2/lpmos/param.scs[3s], /pkg/xfab2/XKIT/xh018/cadence/v9_0/spectre/v9_0_2/lpmos/bip.scs[tm], /pkg/xfab2/XKIT/xh018/cadence/v9_0/spectre/v9_0_2/lpmos/cap.scs[wp ws], /pkg/xfab2/XKIT/xh018/cadence/v9_0/spectre/v9_0_2/lpmos/dio.scs[tm], /pkg/xfab2/XKIT/xh018/cadence/v9_0/spectre/v9_0_2/lpmos/mos.scs[wp ws wo wz], /pkg/xfab2/XKIT/xh018/cadence/v9_0/spectre/v9_0_2/lpmos/photo.scs[tm], /pkg/xfab2/XKIT/xh018/cadence/v9_0/spectre/v9_0_2/lpmos/res.scs[wp ws]
  P (off): VDD=1.8
  PT (off): temperature=-20 85; VDD=1.8
  PT_wakeup (off): temperature=-20 85; VDD=0
  PVT (off): temperature=-20 85; VDD=1.62 1.98
