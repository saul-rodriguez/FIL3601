ADE simulation setup
Run mode: Monte Carlo Sampling
Tests:
  CORNER (off): EX1/s2_bias_10/schematic, simulator spectre
  MC: EX1/s2_bias_10/schematic, simulator spectre
    Outputs: Gain_dB
Global variables:
  IN_DC = 0
  IN = 1
  VDD = 1.8
Corners (all switched off):
  model folders: /pkg/xfab2/XKIT/xh018/cadence/v9_0/spectre/v9_0_2/lpmos
  PT (off): temperature=-20 85; config.scs[default], param.scs[3s], bip.scs[tm], cap.scs[wp ws], dio.scs[tm], mos.scs[wp ws wo wz], photo.scs[tm], res.scs[wp ws]
  PVT (off): temperature=-20 85; VDD=1.62 1.98; config.scs[default], param.scs[3s], bip.scs[tm], cap.scs[wp ws], dio.scs[tm], mos.scs[wp ws wo wz], photo.scs[tm], res.scs[wp ws]
Monte Carlo Sampling options: mcmethod=all, mcnumpoints=300, parasiticanalysis=0
