ADE simulation setup
Run mode: Monte Carlo Sampling
Tests:
  EX1:s1_feedback:1 (off): EX1/s1_feedback/schematic, simulator spectre
  EX1:s1_feedback_MC: EX1/s1_feedback/schematic, simulator spectre
Monte Carlo Sampling options: mcmethod=all, mcnumpoints=300, parasiticanalysis=0
