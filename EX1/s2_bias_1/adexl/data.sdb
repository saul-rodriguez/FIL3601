ADE simulation setup
Run mode: Single Run, Sweeps and Corners
Tests:
  EX1:s2_bias_1:1: EX1/s2_bias_1/schematic, simulator spectre
    Outputs: Gain; IM2; IM3; Gain_dB
Global variables:
  IN_DC = 0
  IN = 1
