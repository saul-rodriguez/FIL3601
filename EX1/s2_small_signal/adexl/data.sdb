ADE simulation setup
Run mode: Single Run, Sweeps and Corners
Tests:
  closed_loop: EX1/s2_small_signal/schematic, simulator spectre
    Outputs: Gain_dB
  asymptotic: EX1/s2_small_signal/schematic, simulator spectre
    Outputs: "/(dB20(/R3/PLUS))"; /R3/PLUS
  AB: EX1/s2_small_signal/schematic, simulator spectre
    Outputs: (VF("/VB") * pv("/gm" "value" ?result "variables")); AB; dB20((VF("/VB") * pv("/gm" "value" ?result "variables"))); AB_dB; AB_phase
  root_locus: EX1/s2_small_signal/schematic, simulator spectre
Global variables:
  gm1 = 15.7280e-3 (off)
  rds1 = 2876.39
  cgs1 = 245.32e-15
  cgb1 = 82.23e-15
  cgd1 = 66.05e-15
  cds1 = 101.47e-15
  cdb1 = 208.85e-15
  gm4 = 11.7707e-3
  rds4 = 2327.61
  cgs4 = 295.43e-15
  cgb4 = 42.11e-15
  cgd4 = 64.07e-15
  cds4 = 0.39e-15
  cdb4 = 160.50e-15
  gm1_cpy = 15.728m
  IT = 0 (off)
  IN = 1 (off)
