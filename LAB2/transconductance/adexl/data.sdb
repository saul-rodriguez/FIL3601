ADE simulation setup
Run mode: Single Run, Sweeps and Corners
Tests:
  Af: LAB2/transconductance/schematic, simulator spectre
  Asymptotic: LAB2/transconductance/schematic, simulator spectre
  LoopGain: LAB2/transconductance/schematic, simulator spectre
    Outputs: AB
  rootlocus: LAB2/transconductance/schematic, simulator spectre
Global variables:
  cdb1 = 773.6f
  cds1 = 454.7f
  cgb1 = 160.82f
  cgd1 = 24.60f
  cgs1 = 111.69f
  gm1 = 0.2266m (off)
  rds1 = 23885929.34
  VIN = 0 (off)
  IT = 1 (off)
  gm = 0.227m
