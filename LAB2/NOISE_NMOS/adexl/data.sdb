ADE simulation setup
Run mode: Single Run, Sweeps and Corners
Tests:
  NoiseVoltage: DAY5/NOISE_NMOS/schematic, simulator spectre
  NoiseCurrent (off): DAY5/NOISE_NMOS/schematic, simulator spectre
Global variables:
  IDS = 10u
  L = 1u
  NF = 8
  VDS = 0.9
  WF = 10u
