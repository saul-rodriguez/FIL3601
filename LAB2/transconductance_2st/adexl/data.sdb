ADE simulation setup
Run mode: Single Run, Sweeps and Corners
Tests:
  Af: LAB2/transconductance_2st/schematic, simulator spectre
  Asymptotic: LAB2/transconductance_2st/schematic, simulator spectre
  LoopGain: LAB2/transconductance_2st/schematic, simulator spectre
    Outputs: AB
  rootlocus: LAB2/transconductance_2st/schematic, simulator spectre
Global variables:
  cdb1 = 160f
  cds1 = 46.01f
  cgb1 = 160.37f
  cgd1 = 26.40f
  cgs1 = 112.78f
  gm1 = 0.227m (off)
  rds1 = 23893065.17
  VIN = 0 (off)
  IT = 1 (off)
  gm = 0.227m
  cdb2 = 80.2f
  cds2 = 0.01f
  cgb2 = 43.9f
  cgd2 = 32f
  cgs2 = 50.68f
  gm2 = 0.4320m
  rds2 = 86769
