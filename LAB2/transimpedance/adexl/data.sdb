ADE simulation setup
Run mode: Single Run, Sweeps and Corners
Tests:
  LAB2:transimpedance:1: LAB2/transimpedance/schematic, simulator spectre
Global variables:
  IDS = 10u
  L = 0.18u
  NF = 4
  VDS = 0.5
  VGS = 0.29948
  WF = 8u
