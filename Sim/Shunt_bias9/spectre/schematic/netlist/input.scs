// Design: LAB4/Shunt_bias9
simulator lang=spectre
global 0
parameters IS=1
include "/opt/pdk/xfab/XKIT/xh018/cadence/v10_0/spectre/v10_0_2/lpmos/config.scs" section=default
include "/opt/pdk/xfab/XKIT/xh018/cadence/v10_0/spectre/v10_0_2/lpmos/param.scs" section=3s
include "/opt/pdk/xfab/XKIT/xh018/cadence/v10_0/spectre/v10_0_2/lpmos/bip.scs" section=tm
include "/opt/pdk/xfab/XKIT/xh018/cadence/v10_0/spectre/v10_0_2/lpmos/cap.scs" section=tm
include "/opt/pdk/xfab/XKIT/xh018/cadence/v10_0/spectre/v10_0_2/lpmos/dio.scs" section=tm
include "/opt/pdk/xfab/XKIT/xh018/cadence/v10_0/spectre/v10_0_2/lpmos/mos.scs" section=tm
include "/opt/pdk/xfab/XKIT/xh018/cadence/v10_0/spectre/v10_0_2/lpmos/photo.scs" section=tm
include "/opt/pdk/xfab/XKIT/xh018/cadence/v10_0/spectre/v10_0_2/lpmos/res.scs" section=tm

// LAB4/Shunt_bias9/schematic
M14 (net11 net11 net6 0) nel w=10u l=5u m=(10)*(1)
M12 (net6 net6 net8 0) nel w=10u l=5u m=(10)*(1)
M11 (net8 net8 net7 0) nel w=10u l=5u m=(10)*(1)
M10 (net7 net7 net1 0) nel w=10u l=5u m=(10)*(1)
M9 (net1 net1 0 0) nel w=10u l=5u m=(10)*(1)
M7 (net12 net4 0 0) nel w=10u l=5u m=(2)*(1)
M6 (VOUT net4 0 0) nel w=10u l=5u m=(10)*(1)
M5 (net2 net4 0 0) nel w=10u l=5u m=(20)*(1)
M4 (net4 net4 0 0) nel w=10u l=5u m=(2)*(1)
M2 (net10 net8 net2 0) nel w=10u l=1u m=(8)*(1)
M0 (net9 net3 net2 0) nel w=10u l=1u m=(8)*(1)
M13 (net9 net9 net11 net11) pel w=4u l=1u m=(1)*(4)
M8 (net10 net9 net11 net11) pel w=4u l=1u m=(1)*(4)
M1 (net12 net12 net11 net11) pel w=4u l=2u m=(1)*(2)
M3 (VOUT net10 net11 net11) pel w=8u l=250.0n m=(1)*(10)
V1 (net11 0) vsource dc=1.8 type=dc
I24 (net11 net4) isource dc=2u type=dc
C4 (VG net3) capacitor c=1u
C2 (net3 VOUT) capacitor c=35f
C1 (VG 0) capacitor c=2p
C0 (VOUT 0) capacitor c=100f
R2 (0 VG) resistor r=100k
R0 (net3 VOUT) resistor r=1M
I7 (0 VG) isource mag=IS type=sine
C6 (net8 0 0) mosvc w=20u l=20u m=(3)*(1) par1=(3)*(1) xf_subext=0
C5 (net11 net12 0) mosvc w=20u l=20u m=(3)*(1) par1=(3)*(1) xf_subext=0
C3 (net4 0 0) mosvc w=20u l=20u m=(3)*(1) par1=(3)*(1) xf_subext=0
simulatorOptions options temp=27
dcOp dc
ac ac start=0.01 stop=100M dec=30
pz ( VOUT ) pz iprobe=I7 freq=1
noise ( VOUT ) noise start=0.01 stop=100M dec=30 iprobe=I7 annotate=status
