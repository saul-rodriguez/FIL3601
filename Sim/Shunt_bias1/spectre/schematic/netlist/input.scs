// Design: LAB4/Shunt_bias1
simulator lang=spectre
global 0
parameters IS=1
include "/opt/pdk/xfab/XKIT/xh018/cadence/v10_0/spectre/v10_0_2/lpmos/config.scs" section=default
include "/opt/pdk/xfab/XKIT/xh018/cadence/v10_0/spectre/v10_0_2/lpmos/param.scs" section=3s
include "/opt/pdk/xfab/XKIT/xh018/cadence/v10_0/spectre/v10_0_2/lpmos/bip.scs" section=tm
include "/opt/pdk/xfab/XKIT/xh018/cadence/v10_0/spectre/v10_0_2/lpmos/cap.scs" section=tm
include "/opt/pdk/xfab/XKIT/xh018/cadence/v10_0/spectre/v10_0_2/lpmos/dio.scs" section=tm
include "/opt/pdk/xfab/XKIT/xh018/cadence/v10_0/spectre/v10_0_2/lpmos/mos.scs" section=tm
include "/opt/pdk/xfab/XKIT/xh018/cadence/v10_0/spectre/v10_0_2/lpmos/photo.scs" section=tm
include "/opt/pdk/xfab/XKIT/xh018/cadence/v10_0/spectre/v10_0_2/lpmos/res.scs" section=tm

// LAB4/Shunt_bias1/schematic
M2 (net5 net6 net2 net2) nel w=10u l=1u m=(8)*(1)
M0 (net3 net1 net2 net2) nel w=10u l=1u m=(8)*(1)
M3 (net7 net8 0 0) pel w=8u l=250.0n m=(1)*(10)
V5 (net9 net8) vsource dc=300.9m type=dc
V4 (VOUT net7) vsource dc=900.0m type=dc
V3 (net5 net9) vsource dc=900.0m type=dc
V2 (net6 0) vsource dc=371.7m type=dc
V1 (net3 0) vsource dc=900.0m type=dc
V0 (net1 VG) vsource dc=371.7m type=dc
I3 (net7 0) isource dc=10u type=dc
I2 (net2 net5) isource dc=10u type=dc
I0 (net2 net3) isource dc=10u type=dc
C2 (VG VOUT) capacitor c=30f
C1 (VG 0) capacitor c=2p
C0 (VOUT 0) capacitor c=100f
R2 (0 VG) resistor r=100k
R0 (VG VOUT) resistor r=1M
I7 (0 VG) isource mag=IS type=sine
simulatorOptions options temp=27
dcOp dc
ac ac start=0.01 stop=100M dec=30
pz ( VOUT ) pz iprobe=I7 freq=1
