// Design: LAB3/static
simulator lang=spectre
global 0
parameters IS=0 IDS=10u L=1u NF=10 VDS=500m VGS=0.37179 WF=8u
include "/opt/pdk/xfab/XKIT/xh018/cadence/v10_0/spectre/v10_0_2/lpmos/config.scs" section=default
include "/opt/pdk/xfab/XKIT/xh018/cadence/v10_0/spectre/v10_0_2/lpmos/param.scs" section=3s
include "/opt/pdk/xfab/XKIT/xh018/cadence/v10_0/spectre/v10_0_2/lpmos/bip.scs" section=tm
include "/opt/pdk/xfab/XKIT/xh018/cadence/v10_0/spectre/v10_0_2/lpmos/cap.scs" section=tm
include "/opt/pdk/xfab/XKIT/xh018/cadence/v10_0/spectre/v10_0_2/lpmos/dio.scs" section=tm
include "/opt/pdk/xfab/XKIT/xh018/cadence/v10_0/spectre/v10_0_2/lpmos/mos.scs" section=tm
include "/opt/pdk/xfab/XKIT/xh018/cadence/v10_0/spectre/v10_0_2/lpmos/photo.scs" section=tm
include "/opt/pdk/xfab/XKIT/xh018/cadence/v10_0/spectre/v10_0_2/lpmos/res.scs" section=tm

// LAB3/static/schematic
I0 (OUT net3) isource dc=IDS type=dc
I5 (0 net2) isource dc=10u type=dc
M0 (net3 net6 OUT OUT) nel w=WF l=L m=(1)*(NF)
M1 (net2 net1 0 0) nel w=8u l=1u m=(1)*(10)
V3 (net3 0) vsource dc=VDS type=dc
V2 (net6 net4) vsource dc=VGS type=dc
V0 (net2 net4) vsource dc=500m type=dc
V1 (net1 net7) vsource dc=371.79m type=dc
R2 (0 OUT) resistor r=20k
R0 (net7 0) resistor r=100k
R1 (net7 OUT) resistor r=1M
I3 (0 net7) isource dc=IS mag=1 type=sine
C0 (net7 0) capacitor c=4p
simulatorOptions options temp=27
dcOp dc
dc dc param=IS start=-1u stop=1u step=10n
