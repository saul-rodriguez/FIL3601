// Design: DAY6/ex2
simulator lang=spectre
global 0
parameters VIN2=0
include "/opt/pdk/xfab/XKIT/xh018/cadence/v10_0/spectre/v10_0_2/lpmos/config.scs" section=default
include "/opt/pdk/xfab/XKIT/xh018/cadence/v10_0/spectre/v10_0_2/lpmos/param.scs" section=3s
include "/opt/pdk/xfab/XKIT/xh018/cadence/v10_0/spectre/v10_0_2/lpmos/bip.scs" section=tm
include "/opt/pdk/xfab/XKIT/xh018/cadence/v10_0/spectre/v10_0_2/lpmos/cap.scs" section=tm
include "/opt/pdk/xfab/XKIT/xh018/cadence/v10_0/spectre/v10_0_2/lpmos/dio.scs" section=tm
include "/opt/pdk/xfab/XKIT/xh018/cadence/v10_0/spectre/v10_0_2/lpmos/mos.scs" section=tm
include "/opt/pdk/xfab/XKIT/xh018/cadence/v10_0/spectre/v10_0_2/lpmos/photo.scs" section=tm
include "/opt/pdk/xfab/XKIT/xh018/cadence/v10_0/spectre/v10_0_2/lpmos/res.scs" section=tm

// DAY6/ex2/schematic
V1 (net3 0) vsource dc=1.8 type=dc
V3 (net2 VOUT2) vsource dc=900m type=dc
V2 (net1 VIN2) vsource dc=394.2m type=dc
V4 (VIN2 0) vsource dc=VIN2 type=dc
I3 (net3 net6) isource dc=70u type=dc
I1 (0 net2) isource dc=100u type=dc
R2 (net6 VIN) resistor r=100k
R0 (net3 VOUT) resistor r=9k
R1 (VOUT2 0) resistor r=9k
M2 (net6 net6 0 0) nel w=8u l=180.0n m=(1)*(4)
M0 (VOUT VIN 0 0) nel w=8u l=180.0n m=(1)*(4)
M1 (net2 net1 0 0) nel w=8u l=180.0n m=(1)*(4)
V5 (net5 0) vsource dc=0 type=sine ampl=10m freq=1K
C0 (VIN net5) capacitor c=1u
simulatorOptions options temp=27
dcOp dc
dc dc param=VIN2 start=-0.9 stop=0.9 step=1m
tran tran stop=6m errpreset=conservative
