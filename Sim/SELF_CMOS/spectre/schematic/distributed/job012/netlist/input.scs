// Design: LAB1/SELF_CMOS
simulator lang=spectre
global 0
parameters VDSP=0.6 VDS=0.9 IDSP=2e-05 IDS=0.000165 WF=8e-06 L=1e-06 NF=10 WFP=1e-05 LP=2.5e-07 NFP=10
include "/opt/pdk/xfab/XKIT/xh018/cadence/v10_0/spectre/v10_0_2/lpmos/config.scs" section=default
include "/opt/pdk/xfab/XKIT/xh018/cadence/v10_0/spectre/v10_0_2/lpmos/param.scs" section=3s
include "/opt/pdk/xfab/XKIT/xh018/cadence/v10_0/spectre/v10_0_2/lpmos/bip.scs" section=tm
include "/opt/pdk/xfab/XKIT/xh018/cadence/v10_0/spectre/v10_0_2/lpmos/cap.scs" section=tm
include "/opt/pdk/xfab/XKIT/xh018/cadence/v10_0/spectre/v10_0_2/lpmos/dio.scs" section=tm
include "/opt/pdk/xfab/XKIT/xh018/cadence/v10_0/spectre/v10_0_2/lpmos/mos.scs" section=tm
include "/opt/pdk/xfab/XKIT/xh018/cadence/v10_0/spectre/v10_0_2/lpmos/photo.scs" section=tm
include "/opt/pdk/xfab/XKIT/xh018/cadence/v10_0/spectre/v10_0_2/lpmos/res.scs" section=tm

// LAB1/SELF_CMOS/schematic
V2 (net3 0) vsource dc=1.8 type=dc
V0 (net5 net2) vsource dc=VDSP type=dc
V1 (net1 0) vsource dc=VDS type=dc
I2 (net2 net3) isource dc=IDSP type=dc
I0 (0 D) isource dc=IDS type=dc
M0 (D G 0 0) nel w=WF l=L m=(1)*(NF)
E1 (net4 net3 net5 net3) vcvs gain=1000
E0 (G 0 D net1) vcvs gain=1000
M1 (net2 net4 net3 net3) pel w=WFP l=LP m=(1)*(NFP)
simulatorOptions options temp=27
dcOp dc
