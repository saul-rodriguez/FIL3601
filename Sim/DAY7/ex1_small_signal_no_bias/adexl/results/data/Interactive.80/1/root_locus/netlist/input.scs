// Design: DAY7/ex1_small_signal_no_bias
simulator lang=spectre
global 0
parameters temperature=27 gm=0.122m IT=0 VIN=1 gm3=0.319m rds3=13.043M cgb3=84.34f cgs3=372.5f cgd3=13.22f cdb3=79.52f cds3=184.79f cdb2=9.65f cds2=0.02f cgb2=3.61f cgd2=3.2f cgs2=26.9f gm2=0.227m rds2=452599 cdb4=66f cds4=0.77f cgb4=178f cgd4=25.65f cgs4=317f gm4=97u rds4=2.355M cdb1=32.99f cds1=0.96f cgb1=35f cgd1=13.2f cgs1=14.9f gm1=0.122m rds1=4.068M
include "/opt/pdk/xfab/XKIT/xh018/cadence/v10_0/spectre/v10_0_2/lpmos/config.scs" section=default
include "/opt/pdk/xfab/XKIT/xh018/cadence/v10_0/spectre/v10_0_2/lpmos/param.scs" section=3s
include "/opt/pdk/xfab/XKIT/xh018/cadence/v10_0/spectre/v10_0_2/lpmos/bip.scs" section=tm
include "/opt/pdk/xfab/XKIT/xh018/cadence/v10_0/spectre/v10_0_2/lpmos/cap.scs" section=tm
include "/opt/pdk/xfab/XKIT/xh018/cadence/v10_0/spectre/v10_0_2/lpmos/dio.scs" section=tm
include "/opt/pdk/xfab/XKIT/xh018/cadence/v10_0/spectre/v10_0_2/lpmos/mos.scs" section=tm
include "/opt/pdk/xfab/XKIT/xh018/cadence/v10_0/spectre/v10_0_2/lpmos/photo.scs" section=tm
include "/opt/pdk/xfab/XKIT/xh018/cadence/v10_0/spectre/v10_0_2/lpmos/res.scs" section=tm

// DAY7/ex1_small_signal_no_bias/schematic
I36 (net2 0) isource mag=IT type=sine
V8 (net14 0) vsource mag=VIN type=sine
R13 (net3 VOUT) resistor r=76k
R11 (VOUT VB) resistor r=180k
R5 (net2 0) resistor r=rds1
R7 (VOUT 0) resistor r=rds2
R10 (VB 0) resistor r=20k
C6 (net2 0) capacitor c=cds1+cdb1
C14 (net3 net2) capacitor c=100f
C7 (net2 0) capacitor c=cgb2 +cgs2
C3 (net14 VB) capacitor c=cgb1/2 +cgs1/2
C2 (VB 0) capacitor c=cgd1
C1 (net14 net2) capacitor c=cgd1
C10 (VOUT 0) capacitor c=cds2+cdb2
C8 (net2 VOUT) capacitor c=cgd2
C13 (net1 VB) capacitor c=50f
C15 (VOUT 0) capacitor c=1p
G1 (VOUT 0 net2 0) vccs gm=gm2
G0 (net2 0 net14 VB) vccs gm=gm1
simulatorOptions options temp=27
pz ( VOUT ) pz iprobe=V8 freq=1 param=gm1 start=0 stop=122u step=5u
