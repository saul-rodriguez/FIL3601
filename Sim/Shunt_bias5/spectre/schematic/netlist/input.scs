// Design: LAB4/Shunt_bias5
simulator lang=spectre
global 0
parameters IS=1
include "/opt/pdk/xfab/XKIT/xh018/cadence/v10_0/spectre/v10_0_2/lpmos/config.scs" section=default
include "/opt/pdk/xfab/XKIT/xh018/cadence/v10_0/spectre/v10_0_2/lpmos/param.scs" section=3s
include "/opt/pdk/xfab/XKIT/xh018/cadence/v10_0/spectre/v10_0_2/lpmos/bip.scs" section=tm
include "/opt/pdk/xfab/XKIT/xh018/cadence/v10_0/spectre/v10_0_2/lpmos/cap.scs" section=tm
include "/opt/pdk/xfab/XKIT/xh018/cadence/v10_0/spectre/v10_0_2/lpmos/dio.scs" section=tm
include "/opt/pdk/xfab/XKIT/xh018/cadence/v10_0/spectre/v10_0_2/lpmos/mos.scs" section=tm
include "/opt/pdk/xfab/XKIT/xh018/cadence/v10_0/spectre/v10_0_2/lpmos/photo.scs" section=tm
include "/opt/pdk/xfab/XKIT/xh018/cadence/v10_0/spectre/v10_0_2/lpmos/res.scs" section=tm

// LAB4/Shunt_bias5/schematic
M2 (net10 net11 net2 net2) nel w=10u l=1u m=(8)*(1)
M0 (net4 VG net2 net2) nel w=10u l=1u m=(8)*(1)
M3 (VOUT net10 net12 net12) pel w=8u l=250.0n m=(1)*(10)
V8 (net12 0) vsource dc=829.2m type=dc
V4 (net8 VOUT) vsource dc=70.8m type=dc
V2 (net11 0) vsource dc=0 type=dc
V1 (net4 0) vsource dc=528.3m type=dc
I17 (VOUT 0) isource dc=10u type=dc
I10 (net2 0) isource dc=20u type=dc
I2 (0 net10) isource dc=10u type=dc
C2 (VG net8) capacitor c=30f
C1 (VG 0) capacitor c=2p
C0 (VOUT 0) capacitor c=100f
R2 (0 VG) resistor r=100k
R0 (VG net8) resistor r=1M
I7 (0 VG) isource mag=IS type=sine
simulatorOptions options temp=27
dcOp dc
ac ac start=0.01 stop=100M dec=30
pz ( VOUT ) pz iprobe=I7 freq=1
