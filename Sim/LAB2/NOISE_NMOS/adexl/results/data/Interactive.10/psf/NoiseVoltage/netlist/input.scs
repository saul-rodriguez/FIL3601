// Design: DAY5/NOISE_NMOS
simulator lang=spectre
global 0
parameters temperature=27 IDS=10u L=1u NF=8 VDS=0.9 WF=10u
include "/opt/pdk/xfab/XKIT/xh018/cadence/v10_0/spectre/v10_0_2/lpmos/config.scs" section=default
include "/opt/pdk/xfab/XKIT/xh018/cadence/v10_0/spectre/v10_0_2/lpmos/param.scs" section=3s
include "/opt/pdk/xfab/XKIT/xh018/cadence/v10_0/spectre/v10_0_2/lpmos/bip.scs" section=tm
include "/opt/pdk/xfab/XKIT/xh018/cadence/v10_0/spectre/v10_0_2/lpmos/cap.scs" section=tm
include "/opt/pdk/xfab/XKIT/xh018/cadence/v10_0/spectre/v10_0_2/lpmos/dio.scs" section=tm
include "/opt/pdk/xfab/XKIT/xh018/cadence/v10_0/spectre/v10_0_2/lpmos/mos.scs" section=tm
include "/opt/pdk/xfab/XKIT/xh018/cadence/v10_0/spectre/v10_0_2/lpmos/photo.scs" section=tm
include "/opt/pdk/xfab/XKIT/xh018/cadence/v10_0/spectre/v10_0_2/lpmos/res.scs" section=tm

// DAY5/NOISE_NMOS/schematic
V0 (net015 0) vsource dc=VDS type=dc
V1 (net8 0) vsource dc=VDS type=dc
I5 (0 net09) isource dc=IDS type=dc
I0 (0 net024) isource dc=IDS type=dc
E1 (net016 0 net08 net015) vcvs gain=1000
E0 (net9 0 net03 net8) vcvs gain=1000
C4 (net05 net021) capacitor c=1
C3 (net08 0) capacitor c=1
C2 (net013 net09) capacitor c=1
C1 (net5 net024) capacitor c=1
C0 (net03 0) capacitor c=1
R3 (net09 net08) resistor r=10M
R2 (net024 net03) resistor r=10M
R1 (net05 net016) resistor r=100M isnoisy=no
R0 (net04 net9) resistor r=100M isnoisy=no
IPRB1 (0 net013) iprobe
IPRB0 (0 net5) iprobe
I6 (0 net04) isource mag=1 type=sine
V2 (net021 0) vsource mag=1 type=sine
M1 (net09 net05 0 0) nel w=WF l=L m=(1)*(NF)
M0 (net024 net04 0 0) nel w=WF l=L m=(1)*(NF)
simulatorOptions options temp=27
noise noise start=0.01 stop=100G dec=20 oprobe=IPRB1 iprobe=V2
