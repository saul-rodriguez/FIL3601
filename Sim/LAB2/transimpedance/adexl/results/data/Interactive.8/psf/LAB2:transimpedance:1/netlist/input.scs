// Design: LAB2/transimpedance
simulator lang=spectre
global 0
parameters temperature=27 IDS=10u L=0.18u NF=4 VDS=0.5 VGS=0.29948 WF=8u
include "/opt/pdk/xfab/XKIT/xh018/cadence/v10_0/spectre/v10_0_2/lpmos/config.scs" section=default
include "/opt/pdk/xfab/XKIT/xh018/cadence/v10_0/spectre/v10_0_2/lpmos/param.scs" section=3s
include "/opt/pdk/xfab/XKIT/xh018/cadence/v10_0/spectre/v10_0_2/lpmos/bip.scs" section=tm
include "/opt/pdk/xfab/XKIT/xh018/cadence/v10_0/spectre/v10_0_2/lpmos/cap.scs" section=tm
include "/opt/pdk/xfab/XKIT/xh018/cadence/v10_0/spectre/v10_0_2/lpmos/dio.scs" section=tm
include "/opt/pdk/xfab/XKIT/xh018/cadence/v10_0/spectre/v10_0_2/lpmos/mos.scs" section=tm
include "/opt/pdk/xfab/XKIT/xh018/cadence/v10_0/spectre/v10_0_2/lpmos/photo.scs" section=tm
include "/opt/pdk/xfab/XKIT/xh018/cadence/v10_0/spectre/v10_0_2/lpmos/res.scs" section=tm

// LAB2/transimpedance/schematic
V0 (net2 net3) vsource dc=VDS type=dc
V1 (net1 net5) vsource dc=VGS type=dc
M1 (net2 net1 0 0) nel w=WF l=L m=(1)*(NF)
I5 (0 net2) isource dc=IDS type=dc
E0 (VOUT 0 net3 0) vcvs gain=1000
R0 (net5 0) resistor r=100k
R1 (net5 VOUT) resistor r=1M
I1 (0 net5) isource mag=1 type=sine
C1 (VOUT 0) capacitor c=1p
C0 (net5 0) capacitor c=4p
simulatorOptions options temp=27
ac ac start=0.01 stop=1G dec=30
noise ( VOUT ) noise start=0.01 stop=1G dec=30 iprobe=I1 annotate=status
dcOp dc
