// Design: LAB2/transconductance
simulator lang=spectre
global 0
parameters temperature=27 gm=0.227m IT=0 cdb1=77.36f cds1=45.47f cgb1=160.82f cgd1=0.2640f cgs1=111.69f gm1=1000 rds1=23885929.34 VIN=1
include "/opt/pdk/xfab/XKIT/xh018/cadence/v10_0/spectre/v10_0_2/lpmos/config.scs" section=default
include "/opt/pdk/xfab/XKIT/xh018/cadence/v10_0/spectre/v10_0_2/lpmos/param.scs" section=3s
include "/opt/pdk/xfab/XKIT/xh018/cadence/v10_0/spectre/v10_0_2/lpmos/bip.scs" section=tm
include "/opt/pdk/xfab/XKIT/xh018/cadence/v10_0/spectre/v10_0_2/lpmos/cap.scs" section=tm
include "/opt/pdk/xfab/XKIT/xh018/cadence/v10_0/spectre/v10_0_2/lpmos/dio.scs" section=tm
include "/opt/pdk/xfab/XKIT/xh018/cadence/v10_0/spectre/v10_0_2/lpmos/mos.scs" section=tm
include "/opt/pdk/xfab/XKIT/xh018/cadence/v10_0/spectre/v10_0_2/lpmos/photo.scs" section=tm
include "/opt/pdk/xfab/XKIT/xh018/cadence/v10_0/spectre/v10_0_2/lpmos/res.scs" section=tm

// DAY2/MOS_AC/schematic
subckt MOS_AC D G S
parameters _par0 rds cgb cgs cgd cdb cds
    G0 (D S G S) vccs gm=_par0
    R0 (D S) resistor r=rds
    C6 (G S) capacitor c=cgb
    C5 (G S) capacitor c=cgs
    C4 (G D) capacitor c=cgd
    C3 (D S) capacitor c=cdb
    C0 (D S) capacitor c=cds
ends MOS_AC

// LAB2/transconductance/schematic
IPRB0 (VOUT net2) iprobe
R2 (net1 VG) resistor r=1e3
R1 (net2 0) resistor r=1k
R0 (VS 0) resistor r=100e3
V0 (net1 0) vsource mag=VIN type=sine
I4 (VS VOUT) isource mag=IT type=sine
I0 (VOUT VG VS) MOS_AC _par0=gm1 rds=rds1 cgb=cgb1 cgs=cgs1 cgd=cgd1 cdb=cdb1 cds=cds1
simulatorOptions options temp=27
ac ac start=0.01 stop=10G dec=20
pz pz oprobe=IPRB0 iprobe=V0 freq=1 porti=1
save VOUT R1:1
saveOptions options save=selected
