// Design: DAY8/trans_dc_bias4
simulator lang=spectre
global 0
parameters IN=0
include "/opt/pdk/xfab/XKIT/xh018/cadence/v10_0/spectre/v10_0_2/lpmos/config.scs" section=default
include "/opt/pdk/xfab/XKIT/xh018/cadence/v10_0/spectre/v10_0_2/lpmos/param.scs" section=3s
include "/opt/pdk/xfab/XKIT/xh018/cadence/v10_0/spectre/v10_0_2/lpmos/bip.scs" section=tm
include "/opt/pdk/xfab/XKIT/xh018/cadence/v10_0/spectre/v10_0_2/lpmos/cap.scs" section=tm
include "/opt/pdk/xfab/XKIT/xh018/cadence/v10_0/spectre/v10_0_2/lpmos/dio.scs" section=tm
include "/opt/pdk/xfab/XKIT/xh018/cadence/v10_0/spectre/v10_0_2/lpmos/mos.scs" section=tm
include "/opt/pdk/xfab/XKIT/xh018/cadence/v10_0/spectre/v10_0_2/lpmos/photo.scs" section=tm
include "/opt/pdk/xfab/XKIT/xh018/cadence/v10_0/spectre/v10_0_2/lpmos/res.scs" section=tm

// DAY8/trans_dc_bias4/schematic
M14 (net13 net13 0 0) nel w=1u l=1u m=(1)*(4)
M13 (net12 net13 0 0) nel w=1u l=1u m=(1)*(4)
M7 (net4 net5 0 0) nel w=5u l=4u m=(1)*(1)
M3 (net2 net5 0 0) nel w=5u l=4u m=(40)*(1)
M4 (net5 net5 0 0) nel w=5u l=4u m=(2)*(1)
M0 (VOUT net12 0 0) nel w=5u l=1u m=(1)*(8)
R2 (net7 VOUT) resistor r=200K
R1 (0 net8) resistor r=100K
R0 (net1 VOUT) resistor r=100K
C5 (net8 net12) capacitor c=50p
C0 (net1 VOUT) capacitor c=25f
C6 (net12 net1) capacitor c=50p
C3 (VOUT 0) capacitor c=100f
V4 (net9 net11) vsource dc=900m type=dc
V3 (VDD 0) vsource dc=1.8 type=dc
I3 (VDD net5) isource dc=100n type=dc
I1 (0 net8) isource dc=IN mag=1 type=sine
M8 (net4 net4 VDD VDD) pel w=5u l=2.5u m=(1)*(1)
M9 (net6 net4 VDD VDD) pel w=5u l=2.5u m=(1)*(1)
M6 (net12 net9 net6 VDD) pel w=1u l=2u m=(10)*(1)
M5 (net13 net7 net6 VDD) pel w=1u l=2u m=(10)*(1)
M2 (net2 net2 VDD VDD) pel w=5u l=2.5u m=(1)*(1)
M1 (VOUT net2 VDD VDD) pel w=5u l=2.5u m=(10)*(1)
C7 (VDD net4 0) mosvc w=20u l=10u m=(1)*(1) par1=(1)*(1) xf_subext=0
C8 (net7 0 0) mosvc w=30u l=30u m=(5)*(1) par1=(5)*(1) xf_subext=0
C2 (VDD net2 0) mosvc w=20u l=10u m=(1)*(1) par1=(1)*(1) xf_subext=0
V0 (net11 0) vsource type=pulse val0=0 val1=100m period=1 delay=400u rise=10n fall=1n width=500.0m
simulatorOptions options temp=27
dcOp dc
noise ( VOUT ) noise start=0.01 stop=200M dec=20 iprobe=I1 annotate=status
ac ac start=0.01 stop=100M dec=20
pz ( VOUT ) pz iprobe=V4 freq=1
tran tran stop=2m errpreset=conservative
save VOUT
