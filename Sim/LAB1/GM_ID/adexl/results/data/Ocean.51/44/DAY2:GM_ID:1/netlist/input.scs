// Design: LAB1/GM_ID
simulator lang=spectre
global 0
parameters temperature=27 VDS=0.9 IDS=19.95262315u WF=8e-6 L=250e-9 NF=40
include "/opt/pdk/xfab/XKIT/xh018/cadence/v10_0/spectre/v10_0_2/lpmos/config.scs" section=default
include "/opt/pdk/xfab/XKIT/xh018/cadence/v10_0/spectre/v10_0_2/lpmos/param.scs" section=3s
include "/opt/pdk/xfab/XKIT/xh018/cadence/v10_0/spectre/v10_0_2/lpmos/bip.scs" section=tm
include "/opt/pdk/xfab/XKIT/xh018/cadence/v10_0/spectre/v10_0_2/lpmos/cap.scs" section=tm
include "/opt/pdk/xfab/XKIT/xh018/cadence/v10_0/spectre/v10_0_2/lpmos/dio.scs" section=tm
include "/opt/pdk/xfab/XKIT/xh018/cadence/v10_0/spectre/v10_0_2/lpmos/mos.scs" section=tm
include "/opt/pdk/xfab/XKIT/xh018/cadence/v10_0/spectre/v10_0_2/lpmos/photo.scs" section=tm
include "/opt/pdk/xfab/XKIT/xh018/cadence/v10_0/spectre/v10_0_2/lpmos/res.scs" section=tm

// LAB1/GM_ID/schematic
V1 (net1 0) vsource dc=VDS type=dc
I0 (0 D) isource dc=IDS type=dc
M0 (D G 0 0) nel w=WF l=L m=(1)*(NF)
E0 (G 0 D net1) vcvs gain=1000
simulatorOptions options temp=27
dcOp dc
