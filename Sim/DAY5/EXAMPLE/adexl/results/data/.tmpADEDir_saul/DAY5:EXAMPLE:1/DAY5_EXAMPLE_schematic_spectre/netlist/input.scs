// Design: DAY5/EXAMPLE
simulator lang=spectre
global 0
parameters temperature=27 IDS=10u L=1u NF=8 VDS=0.9 VGS=0.3723 WF=10u
include "/opt/pdk/xfab/XKIT/xh018/cadence/v10_0/spectre/v10_0_2/lpmos/config.scs" section=default
include "/opt/pdk/xfab/XKIT/xh018/cadence/v10_0/spectre/v10_0_2/lpmos/param.scs" section=3s
include "/opt/pdk/xfab/XKIT/xh018/cadence/v10_0/spectre/v10_0_2/lpmos/bip.scs" section=tm
include "/opt/pdk/xfab/XKIT/xh018/cadence/v10_0/spectre/v10_0_2/lpmos/cap.scs" section=tm
include "/opt/pdk/xfab/XKIT/xh018/cadence/v10_0/spectre/v10_0_2/lpmos/dio.scs" section=tm
include "/opt/pdk/xfab/XKIT/xh018/cadence/v10_0/spectre/v10_0_2/lpmos/mos.scs" section=tm
include "/opt/pdk/xfab/XKIT/xh018/cadence/v10_0/spectre/v10_0_2/lpmos/photo.scs" section=tm
include "/opt/pdk/xfab/XKIT/xh018/cadence/v10_0/spectre/v10_0_2/lpmos/res.scs" section=tm

// DAY5/EXAMPLE/schematic
M1 (net2 net4 0 0) nel w=WF l=L m=(1)*(NF)
I5 (0 net2) isource dc=IDS type=dc
V1 (net4 net5) vsource dc=VGS type=dc
V0 (net2 net3) vsource dc=VDS type=dc
IPRB0 (0 net3) iprobe
L0 (net6 net5) inductor l=2u
R0 (net7 net6) resistor r=500
V2 (net7 0) vsource mag=1 type=sine
simulatorOptions options temp=27
dcOp dc
noise noise start=0.01 stop=100G dec=20 oprobe=IPRB0 iprobe=V2
