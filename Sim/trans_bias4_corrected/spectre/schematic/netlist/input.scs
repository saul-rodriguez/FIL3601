// Design: DAY8/trans_bias4_corrected
simulator lang=spectre
global 0
parameters IN=0
include "/opt/pdk/xfab/XKIT/xh018/cadence/v10_0/spectre/v10_0_2/lpmos/config.scs" section=default
include "/opt/pdk/xfab/XKIT/xh018/cadence/v10_0/spectre/v10_0_2/lpmos/param.scs" section=3s
include "/opt/pdk/xfab/XKIT/xh018/cadence/v10_0/spectre/v10_0_2/lpmos/bip.scs" section=tm
include "/opt/pdk/xfab/XKIT/xh018/cadence/v10_0/spectre/v10_0_2/lpmos/cap.scs" section=tm
include "/opt/pdk/xfab/XKIT/xh018/cadence/v10_0/spectre/v10_0_2/lpmos/dio.scs" section=tm
include "/opt/pdk/xfab/XKIT/xh018/cadence/v10_0/spectre/v10_0_2/lpmos/mos.scs" section=tm
include "/opt/pdk/xfab/XKIT/xh018/cadence/v10_0/spectre/v10_0_2/lpmos/photo.scs" section=tm
include "/opt/pdk/xfab/XKIT/xh018/cadence/v10_0/spectre/v10_0_2/lpmos/res.scs" section=tm

// DAY8/trans_bias4_corrected/schematic
M3 (net2 net5 0 0) nel w=5u l=4u m=(2)*(4)
M4 (net5 net5 0 0) nel w=5u l=4u m=(1)*(4)
M0 (VOUT net3 0 0) nel w=5u l=1u m=(1)*(8)
R1 (0 net1) resistor r=100K
R0 (net3 VOUT) resistor r=100K
C0 (net3 VOUT) capacitor c=25f
C1 (net1 net3) capacitor c=1n
C3 (VOUT 0) capacitor c=100f
V3 (VDD 0) vsource dc=1.8 type=dc
I3 (VDD net5) isource dc=1u type=dc
I1 (0 net1) isource dc=IN mag=1 type=sine
M2 (net2 net2 VDD VDD) pel w=5u l=2.5u m=(1)*(1)
M1 (VOUT net2 VDD VDD) pel w=5u l=2.5u m=(10)*(1)
C5 (VDD 0 0) mosvc w=20u l=10u m=(1)*(1) par1=(1)*(1) xf_subext=0
C4 (net5 0 0) mosvc w=20u l=10u m=(1)*(1) par1=(1)*(1) xf_subext=0
C2 (VDD net2 0) mosvc w=20u l=10u m=(1)*(1) par1=(1)*(1) xf_subext=0
simulatorOptions options temp=27
dcOp dc
noise ( VOUT ) noise start=0.01 stop=200M dec=20 iprobe=I1 annotate=status
ac ac start=0.01 stop=100M dec=20
pz ( VOUT ) pz iprobe=I1 freq=1
save VOUT
