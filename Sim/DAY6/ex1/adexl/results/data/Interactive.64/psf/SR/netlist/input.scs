// Design: DAY6/ex1
simulator lang=spectre
global 0
parameters temperature=27 FREQ=700k VIN=0 VPULSE=-500m
include "/opt/pdk/xfab/XKIT/xh018/cadence/v10_0/spectre/v10_0_2/lpmos/config.scs" section=default
include "/opt/pdk/xfab/XKIT/xh018/cadence/v10_0/spectre/v10_0_2/lpmos/param.scs" section=3s
include "/opt/pdk/xfab/XKIT/xh018/cadence/v10_0/spectre/v10_0_2/lpmos/bip.scs" section=tm
include "/opt/pdk/xfab/XKIT/xh018/cadence/v10_0/spectre/v10_0_2/lpmos/cap.scs" section=tm
include "/opt/pdk/xfab/XKIT/xh018/cadence/v10_0/spectre/v10_0_2/lpmos/dio.scs" section=tm
include "/opt/pdk/xfab/XKIT/xh018/cadence/v10_0/spectre/v10_0_2/lpmos/mos.scs" section=tm
include "/opt/pdk/xfab/XKIT/xh018/cadence/v10_0/spectre/v10_0_2/lpmos/photo.scs" section=tm
include "/opt/pdk/xfab/XKIT/xh018/cadence/v10_0/spectre/v10_0_2/lpmos/res.scs" section=tm

// DAY6/ex1/schematic
M7 (net2 net2 0 0) nel w=10u l=2u m=(4)*(1)
M6 (VOUT net2 0 0) nel w=10u l=2u m=(12)*(1)
M2 (net1 net2 0 0) nel w=10u l=2u m=(2)*(1)
M1 (net3 VOUT net1 0) nel w=10u l=180.0n m=(1)*(1)
M0 (net5 VIN net1 0) nel w=10u l=180.0n m=(1)*(1)
M5 (VOUT net5 net4 net4) pel w=10u l=500n m=(1)*(1)
M4 (net5 net3 net4 net4) pel w=10u l=180.0n m=(1)*(1)
M3 (net3 net3 net4 net4) pel w=10u l=180.0n m=(1)*(1)
R2 (net5 net6) resistor r=2k
V1 (net11 0) vsource dc=900m type=dc
V0 (net4 0) vsource dc=1.8 type=dc
I4 (net4 net2) isource dc=10u type=dc
V2 (VIN net9) vsource mag=1 type=sine ampl=VIN freq=FREQ
C3 (net6 VOUT) capacitor c=2p
C1 (VOUT 0) capacitor c=10p
V3 (net9 net11) vsource type=pulse val0=0 val1=VPULSE delay=1u rise=1n fall=1n width=100u
simulatorOptions options temp=27
tran tran stop=10u errpreset=conservative
ac ac start=0.01 stop=100M dec=20
dcOp dc
