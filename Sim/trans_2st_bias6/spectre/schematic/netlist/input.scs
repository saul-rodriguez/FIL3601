// Design: DAY8/trans_2st_bias6
simulator lang=spectre
global 0
parameters IN=0
include "/opt/pdk/xfab/XKIT/xh018/cadence/v10_0/spectre/v10_0_2/lpmos/config.scs" section=default
include "/opt/pdk/xfab/XKIT/xh018/cadence/v10_0/spectre/v10_0_2/lpmos/param.scs" section=3s
include "/opt/pdk/xfab/XKIT/xh018/cadence/v10_0/spectre/v10_0_2/lpmos/bip.scs" section=tm
include "/opt/pdk/xfab/XKIT/xh018/cadence/v10_0/spectre/v10_0_2/lpmos/cap.scs" section=tm
include "/opt/pdk/xfab/XKIT/xh018/cadence/v10_0/spectre/v10_0_2/lpmos/dio.scs" section=tm
include "/opt/pdk/xfab/XKIT/xh018/cadence/v10_0/spectre/v10_0_2/lpmos/mos.scs" section=tm
include "/opt/pdk/xfab/XKIT/xh018/cadence/v10_0/spectre/v10_0_2/lpmos/photo.scs" section=tm
include "/opt/pdk/xfab/XKIT/xh018/cadence/v10_0/spectre/v10_0_2/lpmos/res.scs" section=tm

// DAY8/trans_2st_bias6/schematic
M4 (net3 net3 0 0) nel w=5u l=4u m=(1)*(4)
M3 (net6 net3 0 0) nel w=5u l=4u m=(2)*(4)
M2 (VDD net7 VOUT 0) nel w=5u l=180.0n m=(1)*(8)
M9 (net8 net3 0 0) nel w=5u l=4u m=(2)*(4)
M1 (net7 net9 net4 0) nel w=5u l=180.0n m=(1)*(8)
M12 (VOUT net3 0 0) nel w=5u l=4u m=(15)*(4)
M11 (net9 net9 net3 0) nel w=5u l=180.0n m=(1)*(4)
M0 (net4 net1 0 0) nel w=5u l=180.0n m=(1)*(8)
R1 (0 net11) resistor r=100K
R2 (0 VOUT) resistor r=100K
R0 (net1 VOUT) resistor r=100K
C17 (net11 0) capacitor c=1p
C0 (net1 VOUT) capacitor c=100f
C1 (net11 net1) capacitor c=1u
V6 (VDD 0) vsource dc=1.8 type=dc
I3 (VDD net9) isource dc=1u type=dc
I1 (0 net11) isource dc=IN mag=1 type=sine
C3 (VDD net8 0) mosvc w=20u l=10u m=(1)*(1) par1=(1)*(1) xf_subext=0
C2 (VDD net6 0) mosvc w=20u l=10u m=(1)*(1) par1=(1)*(1) xf_subext=0
M6 (net13 net6 VDD VDD) pel w=1u l=8u m=(10)*(1)
M5 (net5 net6 VDD VDD) pel w=1u l=8u m=(1)*(1)
M7 (net7 net8 net13 VDD) pel w=5u l=1u m=(10)*(1)
M8 (net6 net8 net5 VDD) pel w=5u l=1u m=(10)*(1)
M10 (net8 net8 VDD VDD) pel w=1u l=5u m=(1)*(1)
simulatorOptions options temp=27
dcOp dc
noise ( VOUT ) noise start=0.01 stop=200M dec=20 iprobe=I1 annotate=status
ac ac start=0.01 stop=100M dec=20
pz ( VOUT ) pz iprobe=I1 freq=1
save VOUT
