ADE simulation setup
Run mode: Single Run, Sweeps and Corners
Tests:
  CHARACTERIZATION:NOISE_NMOS_V:1: CHARACTERIZATION/NOISE_NMOS_V/schematic, simulator spectre
Global variables:
  IDS = 1u
  L = 1u
  NF = 1
  VDS = 1
  WF = 2u
