ADE simulation setup
Run mode: Single Run, Sweeps and Corners
Tests:
  CHARACTERIZATION:NOISE_NMOS:1: CHARACTERIZATION/NOISE_NMOS/schematic, simulator spectre
  CHARACTERIZATION:NOISE_NMOS:2 (off): CHARACTERIZATION/NOISE_NMOS/schematic, simulator spectre
Global variables:
  IDS = 10u,1u,100n,10n
  L = 1u
  NF = 4
  VDS = 1
  WF = 8u
