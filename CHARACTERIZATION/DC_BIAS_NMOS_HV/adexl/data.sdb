ADE simulation setup
Run mode: Single Run, Sweeps and Corners
Tests:
  CHARACTERIZATION:DC_BIAS_NMOS_L:1: CHARACTERIZATION/DC_BIAS_NMOS_HV/schematic, simulator spectre
Global variables:
  VDS = 1
  VGS = 0:0.5:18
  WF = 100u
  NF = 1
