ADE simulation setup
Run mode: Single Run, Sweeps and Corners
Tests:
  VDS (off): CHARACTERIZATION/DC_BIAS_NMOS_L/schematic, simulator spectre
  VGS: CHARACTERIZATION/DC_BIAS_NMOS_L/schematic, simulator spectre
Global variables:
  L1 = 1u
  NF1 = 1
  VDS = {From/To}Linear:0.05:50m:1.8{From/To}
  VGS = {From/To}Linear:0:50m:1.8{From/To} (off)
  WF1 = 10u
