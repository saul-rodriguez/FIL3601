design( "CHARACTERIZATION" "GMID_NMOS_L" "schematic")
modelFile(
    '("/pkg/xfab/XKIT/xh018/cadence/v8_0/spectre/v8_0_1/lpmos/config.scs" "default")
    '("/pkg/xfab/XKIT/xh018/cadence/v8_0/spectre/v8_0_1/lpmos/param.scs" "3s")
    '("/pkg/xfab/XKIT/xh018/cadence/v8_0/spectre/v8_0_1/lpmos/bip.scs" "tm")
    '("/pkg/xfab/XKIT/xh018/cadence/v8_0/spectre/v8_0_1/lpmos/cap.scs" "tm")
    '("/pkg/xfab/XKIT/xh018/cadence/v8_0/spectre/v8_0_1/lpmos/dio.scs" "tm")
    '("/pkg/xfab/XKIT/xh018/cadence/v8_0/spectre/v8_0_1/lpmos/mos.scs" "tm")
    '("/pkg/xfab/XKIT/xh018/cadence/v8_0/spectre/v8_0_1/lpmos/photo.scs" "tm")
    '("/pkg/xfab/XKIT/xh018/cadence/v8_0/spectre/v8_0_1/lpmos/res.scs" "tm")
)
analysis('dc ?saveOppoint t  ?save "all"  )
desVar(	  "IDS1" 0.0008	)
desVar(	  "L1" 3.5e-07	)
desVar(	  "NF1" 40	)
desVar(	  "VDS1" 0.5	)
desVar(	  "WF1" 1e-05	)
envOption(
	'firstRun  t
	'analysisOrder  list("dc" "pz" "dcmatch" "stb" "tran" "envlp" "ac" "lf" "noise" "xf" "sp" "pss" "pac" "pstb" "pnoise" "pxf" "psp" "qpss" "qpac" "qpnoise" "qpxf" "qpsp" "hb" "hbac" "hbstb" "hbnoise" "hbxf" "sens" "acmatch")
	'stopViewList  list("spectre" "veriloga" "ahdl")
	'switchViewList  list("spectre" "veriloga" "ahdl" "cmos_sch" "schematic")
)
option(	'limit  "delta"
	'homotopy  "all"
	'reltol  "100e-6"
)
option( ?categ 'turboOpts
	'uniModeSpectreX  "Spectre"
	'uniMode  "Spectre"
)
saveOption( 'save "all" )
temp( 27 )
