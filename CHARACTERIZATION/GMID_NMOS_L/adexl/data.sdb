ADE simulation setup
Run mode: Single Run, Sweeps and Corners
Tests:
  CHARACTERIZATION:GMID_NMOS_L:1: CHARACTERIZATION/GMID_NMOS_L/schematic, simulator spectre
    Outputs: cgb; gm; pv("I0.M0.m1" "gm" ?result "dcOpInfo"); cgs; cgd; Ctot; ft; gm_id
Global variables:
  IDS1 = {From/To}Decade:10n:10:10000u{From/To}
  L1 = 180n
  NF1 = 20
  VDS1 = 0.9
  WF1 = 10u
