ADE simulation setup
Run mode: Single Run, Sweeps and Corners
Tests:
  V1: DAY1/op_example/schematic, simulator spectre
  V2: DAY1/op_example/schematic, simulator spectre
Global variables:
  VIN2 = 0
  VIN = 0.3942
