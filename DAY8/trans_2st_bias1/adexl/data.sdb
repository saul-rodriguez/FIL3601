ADE simulation setup
Run mode: Single Run, Sweeps and Corners
Tests:
  DAY8:trans_bias1:1: DAY8/trans_bias1/schematic, simulator spectre
    Outputs: deriv(VS("/VOUT"))
Global variables:
  IN = 0
