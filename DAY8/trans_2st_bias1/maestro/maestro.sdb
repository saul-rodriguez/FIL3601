ADE simulation setup
Run mode: Single Run, Sweeps and Corners
Tests:
  DAY8_trans_2st_bias1_1: DAY8/trans_2st_bias1/schematic, simulator spectre
    Variables: IN = 0
