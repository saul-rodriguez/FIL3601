ADE simulation setup
Test DAY8_trans_2st_bias1_1: DAY8/trans_2st_bias1/schematic, simulator spectre
  Models: /pkg/xfab2/XKIT/xh018/cadence/v9_0/spectre/v9_0_2/lpmos/config.scs[default], /pkg/xfab2/XKIT/xh018/cadence/v9_0/spectre/v9_0_2/lpmos/param.scs[3s], /pkg/xfab2/XKIT/xh018/cadence/v9_0/spectre/v9_0_2/lpmos/bip.scs[tm], /pkg/xfab2/XKIT/xh018/cadence/v9_0/spectre/v9_0_2/lpmos/cap.scs[tm], /pkg/xfab2/XKIT/xh018/cadence/v9_0/spectre/v9_0_2/lpmos/dio.scs[tm], /pkg/xfab2/XKIT/xh018/cadence/v9_0/spectre/v9_0_2/lpmos/mos.scs[tm], /pkg/xfab2/XKIT/xh018/cadence/v9_0/spectre/v9_0_2/lpmos/photo.scs[tm], /pkg/xfab2/XKIT/xh018/cadence/v9_0/spectre/v9_0_2/lpmos/res.scs[tm]
  Variables: IN = 0
  Temperature: 27
  Analysis dc: sweep IN start=-9.0u stop=9.0u step=0.01u (saves the operating point)
  Analysis ac: start=0.01 stop=100M dec=20
  Output deriv(VS("/VOUT"))
  Output Poles = pzFrequencyAndRealFilter(getData("poles" ?result "pz"))
  Output Zeros = pzFrequencyAndRealFilter(getData("zeros" ?result "pz"))
  Signals: /VOUT
Run mode: Single Run, Sweeps and Corners
