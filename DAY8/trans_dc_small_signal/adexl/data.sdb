ADE simulation setup
Run mode: Single Run, Sweeps and Corners
Tests:
  Closed_loop: DAY8/trans_dc_small_signal/schematic, simulator spectre
  Asymptotic (off): DAY8/trans_dc_small_signal/schematic, simulator spectre
  AB: DAY8/trans_dc_small_signal/schematic, simulator spectre
    Outputs: AB; AB_dB; AB_Phase; /VB_CMFB
  root_locus (off): DAY8/trans_dc_small_signal/schematic, simulator spectre
Global variables:
  gm3 = 0.319m
  rds3 = 13.043M
  cgb3 = 84.34f
  cgs3 = 372.5f
  cgd3 = 13.22f
  cdb3 = 79.52f
  cds3 = 184.79f
  cdb2 = 1.01f
  cds2 = 0f
  cgb2 = 3.00f
  cgd2 = 0.32f
  cgs2 = 1.76f
  gm2 = 0.0005m (off)
  rds2 = 477245870
  cdb4 = 66f
  cds4 = 0.77f
  cgb4 = 178f
  cgd4 = 25.65f
  cgs4 = 317f
  gm4 = 97u
  rds4 = 2.355M
  cdb1 = 50.76f
  cds1 = 70.30f
  cgb1 = 55.87f
  cgd1 = 13.20f
  cgs1 = 147.43f
  gm1 = 0.3719m (off)
  rds1 = 11287909
  IT = 0 (off)
  VIN = 1 (off)
  gm = 0.3719m
  IN = 1 (off)
