ADE simulation setup
Run mode: Single Run, Sweeps and Corners
Tests:
  Af (off): DAY4/Series/schematic, simulator spectre
  Asymptotic (off): DAY4/Series/schematic, simulator spectre
  LoopGain: DAY4/Series/schematic, simulator spectre
    Outputs: AB
  rootlocus (off): DAY4/Series/schematic, simulator spectre
Global variables:
  cdb1 = 160f
  cds1 = 46.01f
  cgb1 = 160.37f
  cgd1 = 26.40f
  cgs1 = 112.78f
  gm1 = 0.227m (off)
  rds1 = 23893065.17
  VIN = 0 (off)
  IT = 1 (off)
  gm = 0.227m
