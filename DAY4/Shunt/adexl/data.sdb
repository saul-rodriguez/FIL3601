ADE simulation setup
Run mode: Single Run, Sweeps and Corners
Tests:
  Af: DAY4/Shunt/schematic, simulator spectre
  Asymptotic: DAY4/Shunt/schematic, simulator spectre
  LoopGain: DAY4/Shunt/schematic, simulator spectre
    Outputs: AB
  rootlocus: DAY4/Shunt/schematic, simulator spectre
Global variables:
  cdb1 = 160f
  cds1 = 46.01f
  cgb1 = 160.37f
  cgd1 = 26.40f
  cgs1 = 112.78f
  gm1 = 0.227m (off)
  rds1 = 23893065.17
  IT = 1 (off)
  gm = 0.227m
  IS = 1
