ADE simulation setup
Run mode: Single Run, Sweeps and Corners
Tests:
  CSA:csa:1: CSA/csa/schematic, simulator spectre
Global variables:
  Q = 200000*e
  TC = 30n
  e = 1.6e-19
