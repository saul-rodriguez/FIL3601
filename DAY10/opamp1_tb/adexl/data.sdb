ADE simulation setup
Run mode: Single Run, Sweeps and Corners
Tests:
  DAY10:opamp1_tb:1: DAY10/opamp1_tb/config, simulator spectre
