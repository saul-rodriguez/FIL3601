ADE simulation setup
Run mode: Single Run, Sweeps and Corners
Tests:
  DAY2:GM_ID:1: DAY2/GM_ID/schematic, simulator spectre
    Outputs: ids; gm
Global variables:
  IDS = {From/To}Decade:10n:20:10u{From/To}
  L = 180n
  NF = 1
  VDS = 0.9
  WF = 8u
