design( "DAY2" "GM_ID" "schematic")
modelFile(
    '("/opt/pdk/xfab/XKIT/xh018/cadence/v10_0/spectre/v10_0_2/lpmos/config.scs" "default")
    '("/opt/pdk/xfab/XKIT/xh018/cadence/v10_0/spectre/v10_0_2/lpmos/param.scs" "3s")
    '("/opt/pdk/xfab/XKIT/xh018/cadence/v10_0/spectre/v10_0_2/lpmos/bip.scs" "tm")
    '("/opt/pdk/xfab/XKIT/xh018/cadence/v10_0/spectre/v10_0_2/lpmos/cap.scs" "tm")
    '("/opt/pdk/xfab/XKIT/xh018/cadence/v10_0/spectre/v10_0_2/lpmos/dio.scs" "tm")
    '("/opt/pdk/xfab/XKIT/xh018/cadence/v10_0/spectre/v10_0_2/lpmos/mos.scs" "tm")
    '("/opt/pdk/xfab/XKIT/xh018/cadence/v10_0/spectre/v10_0_2/lpmos/photo.scs" "tm")
    '("/opt/pdk/xfab/XKIT/xh018/cadence/v10_0/spectre/v10_0_2/lpmos/res.scs" "tm")
)
analysis('dc ?saveOppoint t  )
desVar(	  "WF" 8e-06	)
desVar(	  "VDS" 0.5	)
desVar(	  "NF" 4	)
desVar(	  "L" 1.8e-07	)
desVar(	  "IDS" 1e-05	)
envOption(
	'analysisOrder  list("dc")
)
temp( 27 )
