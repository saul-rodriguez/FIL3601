ADE simulation setup
Run mode: Single Run, Sweeps and Corners
Tests:
  DAY2:GM_ID:1: LAB1/GM_ID/schematic, simulator spectre
    Outputs: ids; gm; ft; gm_id; av; id
Global variables:
  IDS = {From/To}Decade:1n:10:150u{From/To}
  L = 1u
  NF = 10
  VDS = 0.9
  WF = 8u
