ADE simulation setup
Run mode: Single Run, Sweeps and Corners
Tests:
  VGS_SWEEP: LAB1/BIAS_NMOS/schematic, simulator spectre
  VDS_SWEEP (off): LAB1/BIAS_NMOS/schematic, simulator spectre
Global variables:
  L = 180n
  NF = 1
  VDS = 1
  VGS = {From/To}Linear:1m:50m:1.8{From/To}
  WF = 8u
