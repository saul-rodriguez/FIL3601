ADE simulation setup
Run mode: Single Run, Sweeps and Corners
Tests:
  DAY2:FT:1: LAB1/FT/schematic, simulator spectre
    Outputs: ft
Global variables:
  L = 180n
  NF = 1
  VDS = 0.9
  WF = 10u
  IDS = {From/To}Decade:100n:10:10m{From/To}
