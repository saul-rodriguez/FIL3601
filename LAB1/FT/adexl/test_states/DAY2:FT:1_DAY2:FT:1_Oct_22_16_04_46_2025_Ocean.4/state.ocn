design( "LAB1" "FT" "schematic")
modelFile(
    '("/opt/pdk/xfab/XKIT/xh018/cadence/v10_0/spectre/v10_0_2/lpmos/config.scs" "default")
    '("/opt/pdk/xfab/XKIT/xh018/cadence/v10_0/spectre/v10_0_2/lpmos/param.scs" "3s")
    '("/opt/pdk/xfab/XKIT/xh018/cadence/v10_0/spectre/v10_0_2/lpmos/bip.scs" "tm")
    '("/opt/pdk/xfab/XKIT/xh018/cadence/v10_0/spectre/v10_0_2/lpmos/cap.scs" "tm")
    '("/opt/pdk/xfab/XKIT/xh018/cadence/v10_0/spectre/v10_0_2/lpmos/dio.scs" "tm")
    '("/opt/pdk/xfab/XKIT/xh018/cadence/v10_0/spectre/v10_0_2/lpmos/mos.scs" "tm")
    '("/opt/pdk/xfab/XKIT/xh018/cadence/v10_0/spectre/v10_0_2/lpmos/photo.scs" "tm")
    '("/opt/pdk/xfab/XKIT/xh018/cadence/v10_0/spectre/v10_0_2/lpmos/res.scs" "tm")
)
analysis('ac ?start "0.01"  ?stop "100G"  )
desVar(	  "IDS" 1e-05	)
desVar(	  "L" 1.8e-07	)
desVar(	  "NF" 1	)
desVar(	  "VDS" 0.5	)
desVar(	  "WF" 1e-05	)
envOption(
	'analysisOrder  list("ac" "pz" "dcmatch" "stb" "tran" "envlp" "dc" "lf" "noise" "xf" "sp" "pss" "pac" "pstb" "pnoise" "pxf" "psp" "qpss" "qpac" "qpnoise" "qpxf" "qpsp" "hb" "hbac" "hbstb" "hbnoise" "hbxf" "sens" "acmatch")
)
save( 'i "/IPRB0/MINUS" )
temp( 27 )
