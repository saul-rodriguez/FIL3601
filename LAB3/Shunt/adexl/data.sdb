ADE simulation setup
Run mode: Single Run, Sweeps and Corners
Tests:
  Af: LAB3/Shunt/schematic, simulator spectre
  Asymptotic: LAB3/Shunt/schematic, simulator spectre
  LoopGain: LAB3/Shunt/schematic, simulator spectre
    Outputs: AB; Phase_AB
  rootlocus: LAB3/Shunt/schematic, simulator spectre
Global variables:
  cdb1 = 160f
  cds1 = 46.01f
  cgb1 = 160.37f
  cgd1 = 26.40f
  cgs1 = 112.78f
  gm1 = 0.227m
  rds1 = 23893065.17
  IT = 1 (off)
  gm = 0.227m (off)
  IS = 1
  cdb2 = 36.3f
  cds2 = 0
  cgb2 = 36.3f
  cgd2 = 25.6f
  cgs2 = 28.61f
  gm2 = 0.2291m
  rds2 = 200823
